* PEX produced on Sun Sep 20 05:51:03 PM CEST 2026 using /foss/tools/sak/iic-pex.sh with m=3 and s=1 (extresist threshold=10000 mOhm, minres=1000 mOhm, mindelay=1 ps)
* NGSPICE file created from inverter.ext - technology: sky130A

.subckt inverter VDD VSS A Y
X0 Y A VDD VDD sky130_fd_pr__pfet_01v8 ad=0.6 pd=3.2 as=0.6 ps=3.2 w=1 l=0.15
X1 Y A VSS VSS sky130_fd_pr__nfet_01v8 ad=0.6 pd=3.2 as=0.6 ps=3.2 w=1 l=0.15
C0 Y A 0.03683f
C1 Y VDD 0.06709f
C2 VDD A 0.05048f
C3 Y VSS 0.44299f
C4 VDD VSS 0.82504f
.ends
